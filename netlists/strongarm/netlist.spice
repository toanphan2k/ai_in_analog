* Nominal StrongARM deck; sizing vector is the normalized midpoint (all 0.5).
* Spec: configs\spec_sky130_2ghz.yaml
* Normalized design vector: 0.5, 0.5, 0.5, 0.5, 0.5, 0.5, 0.5, 0.5
* Log-scaled sizing variables map 0.5 to their geometric-mean value.
* sa_nrbo_strongarm StrongARM transient deck (corner=tt, mm=0)
.lib "/usr/local/share/pdk/sky130A/libs.tech/ngspice/sky130.lib.spice" tt
.temp 27
.param VDD=1.8
.param W_IN=4.47
.param L_IN=0.3
.param W_N=4.47
.param L_N=0.15
.param W_P=5.48
.param L_P=0.15
.param W_TAIL=5.48
.param W_EQ=4.47
.param L_EQ=0.39
.param W_RST=4.47
.param L_RST=0.15
VDD vdd 0 1.8
VCK ck 0 PULSE(0 1.8 2.375000e-10 2.500000e-11 2.500000e-11 2.250000e-10 5.000000e-10)
Vinp inp 0 PWL(0.000000e+00 9.500000e-01 6.240000e-10 9.500000e-01 6.250000e-10 8.500000e-01 1.124000e-09 8.500000e-01 1.125000e-09 8.500000e-01 1.624000e-09 8.500000e-01 1.625000e-09 8.500000e-01 2.124000e-09 8.500000e-01 2.125000e-09 8.500000e-01 2.624000e-09 8.500000e-01 2.625000e-09 8.500000e-01 3.124000e-09 8.500000e-01 3.125000e-09 8.500000e-01 3.624000e-09 8.500000e-01 3.625000e-09 8.500000e-01 4.124000e-09 8.500000e-01 4.125000e-09 8.500000e-01 4.624000e-09 8.500000e-01 4.625000e-09 8.500000e-01 5.124000e-09 8.500000e-01 5.125000e-09 8.500000e-01 5.624000e-09 8.500000e-01 5.625000e-09 8.500000e-01 6.124000e-09 8.500000e-01 6.125000e-09 8.500000e-01 6.624000e-09 8.500000e-01 6.625000e-09 8.500000e-01 7.124000e-09 8.500000e-01 7.125000e-09 8.500000e-01 7.624000e-09 8.500000e-01 7.625000e-09 8.500000e-01 8.124000e-09 8.500000e-01 8.125000e-09 8.500000e-01 8.624000e-09 8.500000e-01 8.625000e-09 8.500000e-01 9.124000e-09 8.500000e-01 9.125000e-09 8.500000e-01 9.624000e-09 8.500000e-01 9.625000e-09 8.500000e-01 1.012400e-08 8.500000e-01 1.012500e-08 8.500000e-01 1.062400e-08 8.500000e-01 1.062500e-08 8.500000e-01 1.112400e-08 8.500000e-01 1.112500e-08 8.500000e-01 1.162400e-08 8.500000e-01 1.162500e-08 8.500000e-01 1.212400e-08 8.500000e-01 1.212500e-08 8.500000e-01 1.262400e-08 8.500000e-01 1.262500e-08 8.500000e-01 1.312400e-08 8.500000e-01 1.312500e-08 8.500000e-01 1.362400e-08 8.500000e-01 1.362500e-08 8.500000e-01 1.412400e-08 8.500000e-01 1.412500e-08 8.500000e-01 1.462400e-08 8.500000e-01 1.462500e-08 8.500000e-01 1.512400e-08 8.500000e-01 1.512500e-08 8.500000e-01)
Vinn inn 0 PWL(0.000000e+00 8.500000e-01 6.240000e-10 8.500000e-01 6.250000e-10 9.500000e-01 1.124000e-09 9.500000e-01 1.125000e-09 9.500000e-01 1.624000e-09 9.500000e-01 1.625000e-09 9.500000e-01 2.124000e-09 9.500000e-01 2.125000e-09 9.500000e-01 2.624000e-09 9.500000e-01 2.625000e-09 9.500000e-01 3.124000e-09 9.500000e-01 3.125000e-09 9.500000e-01 3.624000e-09 9.500000e-01 3.625000e-09 9.500000e-01 4.124000e-09 9.500000e-01 4.125000e-09 9.500000e-01 4.624000e-09 9.500000e-01 4.625000e-09 9.500000e-01 5.124000e-09 9.500000e-01 5.125000e-09 9.500000e-01 5.624000e-09 9.500000e-01 5.625000e-09 9.500000e-01 6.124000e-09 9.500000e-01 6.125000e-09 9.500000e-01 6.624000e-09 9.500000e-01 6.625000e-09 9.500000e-01 7.124000e-09 9.500000e-01 7.125000e-09 9.500000e-01 7.624000e-09 9.500000e-01 7.625000e-09 9.500000e-01 8.124000e-09 9.500000e-01 8.125000e-09 9.500000e-01 8.624000e-09 9.500000e-01 8.625000e-09 9.500000e-01 9.124000e-09 9.500000e-01 9.125000e-09 9.500000e-01 9.624000e-09 9.500000e-01 9.625000e-09 9.500000e-01 1.012400e-08 9.500000e-01 1.012500e-08 9.500000e-01 1.062400e-08 9.500000e-01 1.062500e-08 9.500000e-01 1.112400e-08 9.500000e-01 1.112500e-08 9.500000e-01 1.162400e-08 9.500000e-01 1.162500e-08 9.500000e-01 1.212400e-08 9.500000e-01 1.212500e-08 9.500000e-01 1.262400e-08 9.500000e-01 1.262500e-08 9.500000e-01 1.312400e-08 9.500000e-01 1.312500e-08 9.500000e-01 1.362400e-08 9.500000e-01 1.362500e-08 9.500000e-01 1.412400e-08 9.500000e-01 1.412500e-08 9.500000e-01 1.462400e-08 9.500000e-01 1.462500e-08 9.500000e-01 1.512400e-08 9.500000e-01 1.512500e-08 9.500000e-01)
XM1 P inp tail 0 sky130_fd_pr__nfet_01v8 W={W_IN} L={L_IN} AD=1.2963 AS=1.2963 PD=9.52 PS=9.52
XM2 Q inn tail 0 sky130_fd_pr__nfet_01v8 W={W_IN} L={L_IN} AD=1.2963 AS=1.2963 PD=9.52 PS=9.52
XM3 X Y P 0 sky130_fd_pr__nfet_01v8 W={W_N} L={L_N} AD=1.2963 AS=1.2963 PD=9.52 PS=9.52
XM4 Y X Q 0 sky130_fd_pr__nfet_01v8 W={W_N} L={L_N} AD=1.2963 AS=1.2963 PD=9.52 PS=9.52
XM5 X Y vdd vdd sky130_fd_pr__pfet_01v8 W={W_P} L={L_P} AD=1.5892 AS=1.5892 PD=11.54 PS=11.54
XM6 Y X vdd vdd sky130_fd_pr__pfet_01v8 W={W_P} L={L_P} AD=1.5892 AS=1.5892 PD=11.54 PS=11.54
XM7 tail ck 0 0 sky130_fd_pr__nfet_01v8 W={W_TAIL} L={L_N} AD=1.5892 AS=1.5892 PD=11.54 PS=11.54
XM8 P ck Q vdd sky130_fd_pr__pfet_01v8 W={W_EQ} L={L_EQ} AD=1.2963 AS=1.2963 PD=9.52 PS=9.52
XMr1 X ck vdd vdd sky130_fd_pr__pfet_01v8 W={W_RST} L={L_RST} AD=1.2963 AS=1.2963 PD=9.52 PS=9.52
XMr2 Y ck vdd vdd sky130_fd_pr__pfet_01v8 W={W_RST} L={L_RST} AD=1.2963 AS=1.2963 PD=9.52 PS=9.52
CLx X 0 5.000000e-15
CLy Y 0 5.000000e-15
.control

* =====================================================
* STRONGARM TRANSIENT SIMULATION
* =====================================================

set wr_singlescale
set wr_vecnames

* Transient analysis
* Timestep = 0.833 ps
* Stop time = 16 ns
tran 8.333333e-13 1.600000e-08

* =====================================================
* OUTPUT DIFFERENTIAL
* =====================================================

let vdiff = v(X)-v(Y)

* =====================================================
* INSTANTANEOUS POWER
* Positive means power delivered by VDD
* =====================================================

let p_inst = -v(vdd)*i(VDD)

* =====================================================
* POWER MEASUREMENTS
* Ignore initial startup interval
* =====================================================

meas tran p_avg AVG p_inst FROM=5n TO=16n

meas tran p_peak MAX p_inst FROM=5n TO=16n

meas tran e_total INTEG p_inst FROM=5n TO=16n

* =====================================================
* WAVEFORM EXPORT
* =====================================================

wrdata build/netlists/strongarm_nominal_tran.txt v(X) v(Y) v(ck) v(inp) v(inn) vdiff i(VDD) p_inst

* =====================================================
* PRINT RESULTS
* =====================================================

echo =========================================
echo STRONGARM SIMULATION RESULTS
echo =========================================

print p_avg
print p_peak
print e_total

echo =========================================

.endc
.end
